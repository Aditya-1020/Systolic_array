addrmap sysarray_csr {
    name = "Systolic array CSR";
    desc = "10 registers. All data lives in on-chip WBUF/ABUF/RBUF; descriptors are beat indices, not byte addresses.";
    default regwidth = 32;
    default accesswidth = 32;

    // Driven by hardware = BUSY. While high, datapath config fields ignore software writes.
    signal { desc = "1 = array busy, config write-locked."; } cfg_lock;

    // ------------------------------------------------------------------
    // Execution control
    // ------------------------------------------------------------------
    reg {
        name = "COMMAND";
        desc = "Write-1 command pulses, read as 0. ABORT beats LOAD_W/START. LOAD_W + START together -> CMD_ERR.";
        default sw = w;
        default hw = r;
        default singlepulse = true;
        field {desc = "Load bias + weights from WBUF[WEIGHT_ADDR]. Idle only.";} LOAD_W[0:0] = 0;
        field {desc = "Run ACT_COUNT rows from ABUF[ACT_ADDR], write results to RBUF[DST_ADDR]. Needs W_VALID. Idle only.";} START[1:1] = 0;
        field {desc = "Stop now, drop in-flight rows. Keeps W_VALID unless a weight load was cut short.";} ABORT[2:2] = 0;
    } COMMAND @ 0x00;

    reg {
        name = "STATUS";
        desc = "BUSY/W_VALID are live. DONE/CMD_ERR/CFG_ERR are sticky, write-1-to-clear. Hardware set wins over W1C. DONE also clears on an accepted START.";
        field {sw = r; hw = w; desc = "Load or run in progress.";} BUSY[0:0];
        field {sw = r; hw = w; desc = "Bias + weights resident in the array.";} W_VALID[1:1];
        field {sw = rw; hw = r; onwrite = woclr; hwset = true; hwclr = true; precedence = hw; desc = "Last result beat written to RBUF.";} DONE[2:2] = 0;
        field {sw = rw; hw = r; onwrite = woclr; hwset = true; precedence = hw; desc = "Command rejected: illegal sequence (busy, START without W_VALID, LOAD_W+START).";} CMD_ERR[3:3] = 0;
        field {sw = rw; hw = r; onwrite = woclr; hwset = true; precedence = hw; desc = "Command rejected: ACT_COUNT==0 or a range overruns its SRAM.";} CFG_ERR[4:4] = 0;
    } STATUS @ 0x04;

    reg {
        name = "INT_ENABLE";
        desc = "irq = (DONE & DONE_IE) | ((CMD_ERR | CFG_ERR) & ERR_IE)";
        field {sw = rw; hw = r; desc = "Interrupt on DONE.";} DONE_IE[0:0] = 0;
        field {sw = rw; hw = r; desc = "Interrupt on CMD_ERR or CFG_ERR.";} ERR_IE[1:1] = 0;
    } INT_ENABLE @ 0x08;

    // ------------------------------------------------------------------
    // Post-processing (write-locked while BUSY; these flops feed the datapath directly)
    // ------------------------------------------------------------------
    reg {
        name = "POSTPROC_CFG";
        desc = "00 raw GEMM (int32 lanes, 4 beats/row) | 01 ReLU | 11 ReLU+requant | 10 requant only (int8 lanes, 1 beat/row).";
        field {sw = rw; hw = r; swwel = cfg_lock; desc = "ReLU on accumulator.";} RELU_EN[0:0] = 0;
        field {sw = rw; hw = r; swwel = cfg_lock; desc = "Multiply, shift/round, saturate to int8.";} REQUANT_EN[1:1] = 0;
    } POSTPROC_CFG @ 0x0C;

    reg {
        name = "POSTPROC_MULT";
        desc = "Unsigned fixed-point multiplier (15 bits, MULT_W=16).";
        field {sw = rw; hw = r; swwel = cfg_lock;} MULT[14:0] = 0;
    } POSTPROC_MULT @ 0x10;

    reg {
        name = "POSTPROC_SHIFT";
        desc = "Right shift after multiply, round-to-nearest (6 bits, SHIFT_W=6).";
        field {sw = rw; hw = r; swwel = cfg_lock;} SHIFT[5:0] = 0;
    } POSTPROC_SHIFT @ 0x14;

    // ------------------------------------------------------------------
    // SRAM descriptors, in 64-bit beats. Sampled at command accept.
    // ------------------------------------------------------------------
    reg {
        name = "WEIGHT_ADDR";
        desc = "WBUF beat index of a weight block: 2 bias beats (8 x int16, lane 0 first) then 8 weight beats (row 0 first). WBUF is 256 beats.";
        field {sw = rw; hw = r;} ADDR[7:0] = 0;
    } WEIGHT_ADDR @ 0x18;

    reg {
        name = "ACT_ADDR";
        desc = "ABUF beat index of first activation row (8 x int8 per beat). ABUF is 256 beats.";
        field {sw = rw; hw = r;} ADDR[7:0] = 0;
    } ACT_ADDR @ 0x1C;

    reg {
        name = "ACT_COUNT";
        desc = "Number of activation rows, 1..256. 0 or overrun -> CFG_ERR.";
        field {sw = rw; hw = r;} COUNT[8:0] = 0;
    } ACT_COUNT @ 0x20;

    reg {
        name = "DST_ADDR";
        desc = "RBUF beat index of first result beat. Raw: 4 beats/row (lanes 2k,2k+1 in beat k). Requant: 1 beat/row. RBUF is 512 beats.";
        field {sw = rw; hw = r;} ADDR[8:0] = 0;
    } DST_ADDR @ 0x24;
};
