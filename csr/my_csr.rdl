// Systolic array CSR block. Compile with PeakRDL (see command in the notes).
// 9 registers, 32-bit, word-aligned. Data lives in WBUF/ABUF/RBUF windows, not here.
// Addresses below are beat indices into the macros, not byte addresses.
addrmap sys_csr {
    name = "Systolic array CSR";
    desc = "Control/status for the INT8 systolic accelerator. START is a write-1 pulse; the sequencer ignores writes to config while BUSY.";

    default regwidth    = 32;
    default accesswidth = 32;

    reg {
        name = "ID";
        desc = "Block identification, read-only constants.";
        field { name = "BLOCK";   desc = "0x5A01 = systolic array block."; sw = r; hw = na; } BLOCK[31:16]  = 16'h5A01;
        field { name = "VERSION"; desc = "Register map version.";          sw = r; hw = na; } VERSION[15:0] = 16'h0002;
    } ID @ 0x00;

    reg {
        name = "CTRL";
        desc = "Run control.";
        field {
            name = "START";
            desc = "Write 1 to start one run. Self-clearing pulse. Illegal while BUSY or with an out-of-range configuration: sets STATUS.ERR instead.";
            sw = rw; hw = r; singlepulse = true;
        } START[0:0] = 0;
        field {
            name = "W_LOAD";
            desc = "1 = load N weight beats from WBUF[WADDR] before streaming. 0 = reuse the resident weights.";
            sw = rw; hw = r;
        } W_LOAD[1:1] = 0;
        field {
            name = "IRQ_EN";
            desc = "Raise the interrupt output when STATUS.DONE is set.";
            sw = rw; hw = r;
        } IRQ_EN[2:2] = 0;
    } CTRL @ 0x04;

    reg {
        name = "STATUS";
        desc = "BUSY is live. DONE and ERR are sticky, write-1-to-clear; a hardware set wins over a simultaneous clear.";
        field {
            name = "BUSY";
            desc = "A run is in progress.";
            sw = r; hw = w;
        } BUSY[0:0] = 0;
        field {
            name = "DONE";
            desc = "Last run completed and all results are in RBUF.";
            sw = rw; hw = w; we = true; onwrite = woclr; precedence = hw;
        } DONE[1:1] = 0;
        field {
            name = "ERR";
            desc = "START rejected: busy, COUNT outside 1..MAX_ROWS, a buffer range overflow, or PPCFG.SHIFT above the maximum.";
            sw = rw; hw = w; we = true; onwrite = woclr; precedence = hw;
        } ERR[2:2] = 0;
    } STATUS @ 0x08;

    reg {
        name = "DIM";
        desc = "Build constants, tied to the RTL parameters in sys_pkg. Regenerate if the package changes.";
        field { name = "N";        desc = "Array size N.";                   sw = r; hw = na; } N[7:0]         = 8;
        field { name = "DW";       desc = "Data width in bits.";             sw = r; hw = na; } DW[15:8]       = 8;
        field { name = "ACC_W";    desc = "Accumulator width in bits.";      sw = r; hw = na; } ACC_W[23:16]   = 19;
        field { name = "MAX_ROWS"; desc = "Maximum activation rows per run."; sw = r; hw = na; } MAX_ROWS[31:24] = 64;
    } DIM @ 0x0C;

    reg {
        name = "WADDR";
        desc = "WBUF beat index of the first weight beat of the tile.";
        field { name = "ADDR"; desc = "Weight buffer beat index."; sw = rw; hw = r; } ADDR[15:0] = 0;
    } WADDR @ 0x10;

    reg {
        name = "AADDR";
        desc = "ABUF beat index of the first activation row.";
        field { name = "ADDR"; desc = "Activation buffer beat index."; sw = rw; hw = r; } ADDR[15:0] = 0;
    } AADDR @ 0x14;

    reg {
        name = "CADDR";
        desc = "RBUF beat index of the first result beat.";
        field { name = "ADDR"; desc = "Result buffer beat index."; sw = rw; hw = r; } ADDR[15:0] = 0;
    } CADDR @ 0x18;

    reg {
        name = "COUNT";
        desc = "Number of activation rows (beats) to stream, 1..MAX_ROWS.";
        field { name = "ROWS"; desc = "Activation row count."; sw = rw; hw = r; } ROWS[15:0] = 0;
    } COUNT @ 0x1C;

    reg {
        name = "PPCFG";
        desc = "Post-processing. PP_EN=0 clock-gates the post-processor and RBUF receives raw int32 columns (4 beats per row). PP_EN=1 writes int8 rows (1 beat per row): round, arithmetic shift right, optional ReLU, saturate.";
        field { name = "PP_EN"; desc = "1 = requantize to int8, 0 = raw int32 output with the post-processor clock gated off."; sw = rw; hw = r; } PP_EN[0:0]  = 1;
        field { name = "RELU";  desc = "Clamp negative values to zero before saturation.";                                        sw = rw; hw = r; } RELU[1:1]   = 0;
        field { name = "ROUND"; desc = "Add half an LSB (round half up) before the shift.";                                       sw = rw; hw = r; } ROUND[2:2]  = 0;
        field { name = "SHIFT"; desc = "Arithmetic right shift, 0..ACC_W-1.";                                                     sw = rw; hw = r; } SHIFT[12:8] = 0;
    } PPCFG @ 0x20;
};
